# Ansys Electronics Desktop project, version 2021.2
materials:
  vacuum: permittivity=1
  copper: permeability=0.999991 conductivity=58000000

design Q3DDesign1 (Q3D Extractor, model units mm)
options: SParamCalcMethod=EqTransLine Calculate_Lossy_Dielectrics
geometry:
  Circle1 [copper] = circle(normal=X, centre=(0mm, 20mm, 0mm), radius=0.5mm)
  Circle1.helix(XCenter=0mm YCenter=0mm ZCenter=0mm XStartDir=0mm YStartDir=0mm ZStartDir=16mm NumThread=15 RightHand=true RadiusIncrement=0mm Thread=1mm)
boundaries and excitations:
  Source1: Source Faces=Circle1.face(at (0, 20, 0)) TerminalType=ConstantVoltage Net=Circle1
  Circle1: SignalNet Objects=Circle1
  Sink1: Sink Faces=Circle1.face(at (0, 20, 15)) TerminalType=ConstantVoltage Net=Circle1
setups:
  Setup1: Matrix AdaptiveFreq=5MHz Cap{MaxPass=10 MinPass=1 MinConvPass=1 PerError=1 PerRefine=30 AutoIncreaseSolutionOrder SolutionOrder=High Solver_Type=Iterative} DC{Cond{MaxPass=10 MinPass=1 MinConvPass=1 PerError=1 PerRefine=30} Mult{MaxPass=1 MinPass=1 MinConvPass=1 PerError=1 PerRefine=30} Solution_Order=Normal} AC{MaxPass=10 MinPass=1 MinConvPass=1 PerError=1 PerRefine=30} ConstantDelta=0s
source amplitudes:
  Circle1:Source1: AC 1A
  Circle1: Cap 1V 0deg
  Circle1:Source1: DC 1A
